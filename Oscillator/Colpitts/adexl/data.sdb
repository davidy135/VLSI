ADE simulation setup
Run mode: Single Run, Sweeps and Corners
Tests:
  Oscillator:Colpitts:1: Oscillator/Colpitts/schematic, simulator spectre
Global variables:
  C1 = 150f
  C2 = 300f
  F1 = 20
  F2 = 10
  Id = 800u
  L1 = 100n
  L2 = 100n
  R = 30k
  Vb = 500m
  VDD = 1
  W1 = 300u
  W2 = 500u
