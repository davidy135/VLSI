ADE simulation setup
Run mode: Single Run, Sweeps and Corners
Tests:
  Operational_Amplifier:TwoStage_tb:1: Operational_Amplifier/TwoStage_tb/schematic, simulator spectre
Global variables:
  VCM = 500m
  Vcm = 500m
  L1 = 60n
  L2 = 300n
  L3 = 60n
  L4 = 500n
  L5 = 400n
  W1 = 200n:200n:10u
  W2 = 200n
  W3 = 10u
  W4 = 200u
  W5 = 200n
  Im = .4
  f1 = 1:50
  f2 = 2
  f3 = 2
  f4 = 2
  f5 = 2
  Cc = 50f
  Rc = 10k
  CONFIG/Operational_Amplifier/TwoStage_tb = schematic (off)
  Amp = 10m
  CL = 10u
  CW = 10u
