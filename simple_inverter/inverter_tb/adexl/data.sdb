ADE simulation setup
Run mode: Single Run, Sweeps and Corners
Tests:
  simple_inverter:inverter_tb:1: simple_inverter/inverter_tb/schematic, simulator spectre
Global variables:
  V_DD = 0.5:0.1:1.0
